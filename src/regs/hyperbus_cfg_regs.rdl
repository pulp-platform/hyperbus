addrmap hyperbus_cfg_regs {
    desc = "HyperBus controller configuration register map. Enabled chip ranges must be 4 MiB aligned, ordered by chip-select index, and non-overlapping.";

    reg ip_version {
        desc = "IP version (major.minor.patch.revision).";
        field { sw = r; hw = r; reset = 8'd0; } major[31:24];
        field { sw = r; hw = r; reset = 8'd0; } minor[23:16];
        field { sw = r; hw = r; reset = 8'd9; } patch[15:8];
        field { sw = r; hw = r; reset = 8'd0; } revision[7:0];
    };
    reg reg_if_version {
        desc = "Register interface version.";
        field { sw = r; hw = r; reset = 16'd1; } major[31:16];
        field { sw = r; hw = r; reset = 16'd0; } minor[15:0];
    };
    reg capability {
        desc = "Hardware-provided implementation capabilities.";
        field { desc = "Number of implemented chip selects."; sw = r; hw = rw; reset = 8'd0; } num_chips[7:0];
        field { desc = "Number of implemented PHY lanes."; sw = r; hw = rw; reset = 8'd0; } num_phys[15:8];
        field { desc = "Each chip record controls its corresponding chip rather than chip 0 being shared."; sw = r; hw = rw; reset = 1'b0; } per_chip_cfg[16:16];
        field { desc = "Each PHY record controls its corresponding lane rather than PHY 0 being shared."; sw = r; hw = rw; reset = 1'b0; } per_phy_cfg[17:17];
        field { desc = "Per-chip enable bits participate in address decoding."; sw = r; hw = rw; reset = 1'b0; } chip_enable[18:18];
        field { desc = "CLOCK_CFG controls an implemented backend clock divider."; sw = r; hw = rw; reset = 1'b0; } clock_divider[19:19];
        field { desc = "FLUSH and APPLY commands implement a staged configuration barrier."; sw = r; hw = rw; reset = 1'b0; } staged_apply[20:20];
        field { desc = "STATUS reports sticky controller errors."; sw = r; hw = rw; reset = 1'b0; } error_status[21:21];
        field { desc = "Per-chip RWDS sample timing is implemented."; sw = r; hw = rw; reset = 1'b0; } rwds_sample_timing[22:22];
        field { desc = "Per-PHY RWDS output-enable timing is implemented."; sw = r; hw = rw; reset = 1'b0; } rwds_oe_timing[23:23];
    };
    reg command {
        desc = "Single-cycle write-one command strobes, active when capability.staged_apply is set; otherwise writes are retained only as inert pulses.";
        field { sw = rw; hw = r; singlepulse = true; reset = 1'b0; } flush;
        field { sw = rw; hw = r; singlepulse = true; reset = 1'b0; } apply;
    };
    reg status {
        desc = "Controller status.";
        field { sw = rw; hw = rw; onwrite = woclr; hwset = true; precedence = hw; reset = 1'b0; } decode_error;
        field { sw = r; hw = rw; reset = 1'b0; } busy;
        field { sw = r; hw = rw; reset = 1'b0; } dirty;
    };
    reg frontend_cfg {
        desc = "Frontend configuration. dual_phy must be 0 or 1.";
        field { sw = rw; hw = r; reset = 1'b1; } dual_phy;
    };
    reg clock_cfg {
        desc = "Backend clock-divider configuration, active when capability.clock_divider is set; divider values must be at least 2.";
        field { sw = rw; hw = r; reset = 8'd8; } divider[7:0];
    };
    reg tx_delay {
        desc = "PHY transmit delay. PHY 0 is shared when capability.per_phy_cfg is clear.";
        field { sw = rw; hw = r; reset = 8'h10; } value[7:0];
    };
    reg rwds_timing {
        desc = "PHY RWDS output-enable timing. rwds_oe_setup_cycles must be at most 15 and is active when capability.rwds_oe_timing is set.";
        field { sw = rw; hw = r; reset = 8'd1; } rwds_oe_setup_cycles[7:0];
    };
    reg range_base {
        desc = "Inclusive 4 MiB-aligned chip address range base.";
        field { sw = rw; hw = r; reset = 10'd0; } value[31:22];
    };
    reg range_bound {
        desc = "Exclusive 4 MiB-aligned chip address range bound.";
        field { sw = rw; hw = r; reset = 10'd1; } value[31:22];
    };
    reg address_cfg {
        desc = "Chip address-space interpretation and enable. address_space and enable must be 0 or 1, and address_mask_msb must be at most 31. Chip 0 is shared when capability.per_chip_cfg is clear; enable is active when capability.chip_enable is set.";
        field { sw = rw; hw = r; reset = 8'd0; } address_space[7:0];
        field { sw = rw; hw = r; reset = 8'd25; } address_mask_msb[15:8];
        field { sw = rw; hw = r; reset = 1'b1; } enable[16:16];
    };
    reg latency_cfg {
        desc = "Chip latency configuration. t_latency_access must be 3 through 15; rwds_sample_delay must be at most t_latency_access minus 2 and is active when capability.rwds_sample_timing is set. Chip 0 is shared when capability.per_chip_cfg is clear.";
        field { sw = rw; hw = r; reset = 8'd6; } t_latency_access[7:0];
        field { sw = rw; hw = r; reset = 8'd0; } rwds_sample_delay[15:8];
        field { sw = rw; hw = r; reset = 1'b0; } en_latency_additional[16:16];
    };
    reg burst_cfg {
        desc = "Chip burst configuration. Chip 0 is shared when capability.per_chip_cfg is clear.";
        field { sw = rw; hw = r; reset = 16'd350; } t_burst_max[15:0];
    };
    reg chip_timing {
        desc = "Chip-select and read/write timing; byte-backed timing values must be at most 15. Chip 0 is shared when capability.per_chip_cfg is clear.";
        field { sw = rw; hw = r; reset = 8'd6; } t_read_write_recovery[7:0];
        field { sw = rw; hw = r; reset = 8'd1; } t_csh_cycles[15:8];
        field { sw = rw; hw = r; reset = 8'd0; } csn_to_ck_cycles[23:16];
    };
    reg rx_delay {
        desc = "Chip receive delay. Chip 0 is shared when capability.per_chip_cfg is clear.";
        field { sw = rw; hw = r; reset = 8'h10; } value[7:0];
    };
    reg reserved_top {
        desc = "Reserved endpoint that fixes the register window size to 4 KiB.";
        field { sw = r; hw = r; reset = 32'd0; } value[31:0];
    };
    regfile phy_regs {
        tx_delay tx_delay @0x00;
        rwds_timing rwds_timing @0x04;
    };
    regfile chip_regs {
        range_base range_base @0x00;
        range_bound range_bound @0x04;
        address_cfg address_cfg @0x08;
        latency_cfg latency_cfg @0x0c;
        burst_cfg burst_cfg @0x10;
        chip_timing chip_timing @0x14;
        rx_delay rx_delay @0x18;
    };
    regfile global_regs {
        ip_version ip_version @0x000;
        reg_if_version reg_if_version @0x004;
        capability capability @0x008;
        command command @0x00c;
        status status @0x010;
    };
    regfile frontend_regs {
        frontend_cfg frontend_cfg @0x000;
    };
    regfile backend_regs {
        clock_cfg clock_cfg @0x000;
    };
    global_regs global_cfg @0x000;
    frontend_regs frontend @0x100;
    backend_regs backend @0x200;
    phy_regs phy_0 @0x300;
    phy_regs phy_1 @0x340;
    chip_regs chip_0 @0x400;
    chip_regs chip_1 @0x440;
    chip_regs chip_2 @0x480;
    chip_regs chip_3 @0x4c0;
    chip_regs chip_4 @0x500;
    chip_regs chip_5 @0x540;
    chip_regs chip_6 @0x580;
    chip_regs chip_7 @0x5c0;
    chip_1.range_base.value->reset = 10'd1;
    chip_1.range_bound.value->reset = 10'd2;
    chip_2.range_base.value->reset = 10'd2;
    chip_2.range_bound.value->reset = 10'd3;
    chip_3.range_base.value->reset = 10'd3;
    chip_3.range_bound.value->reset = 10'd4;
    chip_4.range_base.value->reset = 10'd4;
    chip_4.range_bound.value->reset = 10'd5;
    chip_5.range_base.value->reset = 10'd5;
    chip_5.range_bound.value->reset = 10'd6;
    chip_6.range_base.value->reset = 10'd6;
    chip_6.range_bound.value->reset = 10'd7;
    chip_7.range_base.value->reset = 10'd7;
    chip_7.range_bound.value->reset = 10'd8;
    reserved_top reserved_top @0xffc;
};
