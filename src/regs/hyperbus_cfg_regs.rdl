addrmap hyperbus_cfg_regs {
    desc = "HyperBus controller configuration. Chip address ranges must be 4 MiB aligned, ordered by chip-select index, and non-overlapping.";

    reg t_latency_access {
        desc = "Initial latency cycles before read or write data.";
        field { sw = rw; hw = r; reset = 4'h6; } value[3:0];
    };

    reg en_latency_additional {
        desc = "Enable additional latency cycles when requested by RWDS.";
        field { sw = rw; hw = r; reset = 1'b0; } value;
    };

    reg t_burst_max {
        desc = "Maximum continuous burst length before the PHY restarts a transfer.";
        field { sw = rw; hw = r; reset = 16'd350; } value[15:0];
    };

    reg t_read_write_recovery {
        desc = "Recovery cycles inserted between read and write phases.";
        field { sw = rw; hw = r; reset = 4'h6; } value[3:0];
    };

    reg t_rx_clk_delay {
        desc = "RX sampling delay with fine taps in bits 4:0 and coarse taps in bits 7:5.";
        field {
            desc = "Fine delay-line tap setting, nominally about 78 ps per tap.";
            sw = rw;
            hw = r;
            reset = 5'h10;
        } fine[4:0];
        field {
            desc = "Coarse delay-line tap setting with an implementation-defined step size.";
            sw = rw;
            hw = r;
            reset = 3'h0;
        } coarse[7:5];
    };

    reg t_tx_clk_delay {
        desc = "TX clock delay with fine taps in bits 4:0 and coarse taps in bits 7:5.";
        field {
            desc = "Fine delay-line tap setting, nominally about 78 ps per tap.";
            sw = rw;
            hw = r;
            reset = 5'h10;
        } fine[4:0];
        field {
            desc = "Coarse delay-line tap setting with an implementation-defined step size.";
            sw = rw;
            hw = r;
            reset = 3'h0;
        } coarse[7:5];
    };

    reg phy_clock_div {
        desc = "System-to-PHY clock division factor used by the isochronous top.";
        field {
            desc = "Must be at least two. Ignored by synchronous and asynchronous tops.";
            sw = rw;
            hw = r;
            reset = 8'd8;
        } value[7:0];
    };

    reg address_mask_msb {
        desc = "Most-significant address bit used by frontend address packing.";
        field { sw = rw; hw = r; reset = 5'd25; } value[4:0];
    };

    reg address_space {
        desc = "Select HyperRAM or HyperFlash address-space interpretation.";
        field { sw = rw; hw = r; reset = 1'b0; } value;
    };

    reg dual_phy {
        desc = "Enable both PHY lanes; when clear, only PHY lane 0 is active.";
        field { sw = rw; hw = r; reset = 1'b1; } value;
    };

    reg t_csh_cycles {
        desc = "Chip-select high time between transfers.";
        field { sw = rw; hw = r; reset = 4'h1; } value[3:0];
    };

    reg csn_to_ck_cycles {
        desc = "Delay cycles from chip-select assertion to clock start.";
        field { sw = rw; hw = r; reset = 4'h0; } value[3:0];
    };

    reg chip0_base {
        desc = "Inclusive 4 MiB-aligned address for chip-select 0 decoding.";
        field { sw = rw; hw = r; reset = 10'd0; } value[31:22];
    };

    reg chip0_bound {
        desc = "Exclusive 4 MiB-aligned address for chip-select 0 decoding.";
        field { sw = rw; hw = r; reset = 10'd1; } value[31:22];
    };

    reg chip1_base {
        desc = "Inclusive 4 MiB-aligned address for chip-select 1 decoding.";
        field { sw = rw; hw = r; reset = 10'd1; } value[31:22];
    };

    reg chip1_bound {
        desc = "Exclusive 4 MiB-aligned address for chip-select 1 decoding.";
        field { sw = rw; hw = r; reset = 10'd2; } value[31:22];
    };

    reg chip2_base {
        desc = "Inclusive 4 MiB-aligned address for chip-select 2 decoding.";
        field { sw = rw; hw = r; reset = 10'd2; } value[31:22];
    };

    reg chip2_bound {
        desc = "Exclusive 4 MiB-aligned address for chip-select 2 decoding.";
        field { sw = rw; hw = r; reset = 10'd3; } value[31:22];
    };

    reg chip3_base {
        desc = "Inclusive 4 MiB-aligned address for chip-select 3 decoding.";
        field { sw = rw; hw = r; reset = 10'd3; } value[31:22];
    };

    reg chip3_bound {
        desc = "Exclusive 4 MiB-aligned address for chip-select 3 decoding.";
        field { sw = rw; hw = r; reset = 10'd4; } value[31:22];
    };

    reg chip4_base {
        desc = "Inclusive 4 MiB-aligned address for chip-select 4 decoding.";
        field { sw = rw; hw = r; reset = 10'd4; } value[31:22];
    };

    reg chip4_bound {
        desc = "Exclusive 4 MiB-aligned address for chip-select 4 decoding.";
        field { sw = rw; hw = r; reset = 10'd5; } value[31:22];
    };

    reg chip5_base {
        desc = "Inclusive 4 MiB-aligned address for chip-select 5 decoding.";
        field { sw = rw; hw = r; reset = 10'd5; } value[31:22];
    };

    reg chip5_bound {
        desc = "Exclusive 4 MiB-aligned address for chip-select 5 decoding.";
        field { sw = rw; hw = r; reset = 10'd6; } value[31:22];
    };

    reg chip6_base {
        desc = "Inclusive 4 MiB-aligned address for chip-select 6 decoding.";
        field { sw = rw; hw = r; reset = 10'd6; } value[31:22];
    };

    reg chip6_bound {
        desc = "Exclusive 4 MiB-aligned address for chip-select 6 decoding.";
        field { sw = rw; hw = r; reset = 10'd7; } value[31:22];
    };

    reg chip7_base {
        desc = "Inclusive 4 MiB-aligned address for chip-select 7 decoding.";
        field { sw = rw; hw = r; reset = 10'd7; } value[31:22];
    };

    reg chip7_bound {
        desc = "Exclusive 4 MiB-aligned address for chip-select 7 decoding.";
        field { sw = rw; hw = r; reset = 10'd8; } value[31:22];
    };

    reg flush {
        desc = "Write to stop accepting requests and drain all in-flight HyperBus operations.";
        field {
            desc = "Writing any value executes the ordering barrier; the value is not stored.";
            sw = w;
            hw = r;
        } request;
    };

    reg status {
        desc = "Sticky protocol and address error status.";
        field {
            desc = "A host request did not match any configured chip address range.";
            sw = rw;
            hw = r;
            woclr;
            hwset;
            precedence = hw;
            reset = 1'b0;
        } decode_error;
    };

    t_latency_access t_latency_access @ 0x00;
    en_latency_additional en_latency_additional @ 0x04;
    t_burst_max t_burst_max @ 0x08;
    t_read_write_recovery t_read_write_recovery @ 0x0c;
    t_rx_clk_delay t_rx_clk_delay @ 0x10;
    t_tx_clk_delay t_tx_clk_delay @ 0x14;
    address_mask_msb address_mask_msb @ 0x18;
    address_space address_space @ 0x1c;
    dual_phy dual_phy @ 0x20;
    t_csh_cycles t_csh_cycles @ 0x28;
    csn_to_ck_cycles csn_to_ck_cycles @ 0x2c;
    chip0_base chip0_base @ 0x30;
    chip0_bound chip0_bound @ 0x34;
    chip1_base chip1_base @ 0x38;
    chip1_bound chip1_bound @ 0x3c;
    chip2_base chip2_base @ 0x40;
    chip2_bound chip2_bound @ 0x44;
    chip3_base chip3_base @ 0x48;
    chip3_bound chip3_bound @ 0x4c;
    flush flush @ 0x50;
    status status @ 0x54;
    chip4_base chip4_base @ 0x58;
    chip4_bound chip4_bound @ 0x5c;
    chip5_base chip5_base @ 0x60;
    chip5_bound chip5_bound @ 0x64;
    chip6_base chip6_base @ 0x68;
    chip6_bound chip6_bound @ 0x6c;
    chip7_base chip7_base @ 0x70;
    chip7_bound chip7_bound @ 0x74;
    phy_clock_div phy_clock_div @ 0x78;
};
